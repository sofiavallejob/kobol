lag
V1 in 0 PWL(0 0 0.01 0 0.0100001 5)
R1 in o 77476.92160987244
C1 o 0 1e-06
.tran 20u 1.2
.control
run
wrdata sp/lag0.3.dat v(o)
.endc
.end
